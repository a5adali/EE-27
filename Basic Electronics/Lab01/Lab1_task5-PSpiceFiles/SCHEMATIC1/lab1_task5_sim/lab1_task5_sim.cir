** Profile: "SCHEMATIC1-lab1_task5_sim"  [ C:\Users\asada\Desktop\Basic Electronics\Lab01\Lab1_task5-PSpiceFiles\SCHEMATIC1\lab1_task5_sim.sim ]

** Creating circuit file "lab1_task5_sim.cir"
** WARNING: THIS AUTOMATICALLY GENERATED FILE MAY BE OVERWRITTEN BY SUBSEQUENT SIMULATIONS

*Libraries:
* Profile Libraries :
* Local Libraries :
.LIB "../../../lab1_task5-pspicefiles/lab1_task5.lib"
* From [PSPICE NETLIST] section of C:\Users\asada\AppData\Roaming\SPB_Data\cdssetup\OrCAD_PSpice\17.2.0\PSpice.ini file:
.lib "nomd.lib"

*Analysis directives:
.DC LIN V_V1 0.1 30 0.1
.OPTIONS ADVCONV
.PROBE64 V(alias(*)) I(alias(*)) W(alias(*)) D(alias(*)) NOISE(alias(*))
.INC "..\SCHEMATIC1.net"

.END
